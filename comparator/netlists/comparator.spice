** sch_path: /home/vicente/iclab/comparator/comparator.sch
**.subckt comparator
VDD VDD 0 dc {vdd}
XM1 net1 CK 0 0 nfet_03v3 L=0.28u W={w1*k1} nf=1 ad='int((nf+1)/2) * W/nf * 0.18u' as='int((nf+2)/2) * W/nf * 0.18u' pd='2*int((nf+1)/2) * (W/nf + 0.18u)'
+ ps='2*int((nf+2)/2) * (W/nf + 0.18u)' nrd='0.18u / W' nrs='0.18u / W' sa=0 sb=0 sd=0
XM2 P vip net1 0 nfet_03v3 L=0.28u W={w1} nf=1 ad='int((nf+1)/2) * W/nf * 0.18u' as='int((nf+2)/2) * W/nf * 0.18u' pd='2*int((nf+1)/2) * (W/nf + 0.18u)'
+ ps='2*int((nf+2)/2) * (W/nf + 0.18u)' nrd='0.18u / W' nrs='0.18u / W' sa=0 sb=0 sd=0
XM3 X Y P 0 nfet_03v3 L=0.28u W={w2} nf=1 ad='int((nf+1)/2) * W/nf * 0.18u' as='int((nf+2)/2) * W/nf * 0.18u' pd='2*int((nf+1)/2) * (W/nf + 0.18u)'
+ ps='2*int((nf+2)/2) * (W/nf + 0.18u)' nrd='0.18u / W' nrs='0.18u / W' sa=0 sb=0 sd=0
XM4 X Y VDD VDD pfet_03v3 L=0.28u W={w2*k2} nf=1 ad='int((nf+1)/2) * W/nf * 0.18u' as='int((nf+2)/2) * W/nf * 0.18u' pd='2*int((nf+1)/2) * (W/nf + 0.18u)'
+ ps='2*int((nf+2)/2) * (W/nf + 0.18u)' nrd='0.18u / W' nrs='0.18u / W' sa=0 sb=0 sd=0
XM5 Q vim net1 0 nfet_03v3 L=0.28u W={w1} nf=1 ad='int((nf+1)/2) * W/nf * 0.18u' as='int((nf+2)/2) * W/nf * 0.18u' pd='2*int((nf+1)/2) * (W/nf + 0.18u)'
+ ps='2*int((nf+2)/2) * (W/nf + 0.18u)' nrd='0.18u / W' nrs='0.18u / W' sa=0 sb=0 sd=0
XM6 Y X Q 0 nfet_03v3 L=0.28u W={w2} nf=1 ad='int((nf+1)/2) * W/nf * 0.18u' as='int((nf+2)/2) * W/nf * 0.18u' pd='2*int((nf+1)/2) * (W/nf + 0.18u)'
+ ps='2*int((nf+2)/2) * (W/nf + 0.18u)' nrd='0.18u / W' nrs='0.18u / W' sa=0 sb=0 sd=0
XM7 Y X VDD VDD pfet_03v3 L=0.28u W={w2*k2} nf=1 ad='int((nf+1)/2) * W/nf * 0.18u' as='int((nf+2)/2) * W/nf * 0.18u' pd='2*int((nf+1)/2) * (W/nf + 0.18u)'
+ ps='2*int((nf+2)/2) * (W/nf + 0.18u)' nrd='0.18u / W' nrs='0.18u / W' sa=0 sb=0 sd=0
XM8 X CK VDD VDD pfet_03v3 L=0.28u W={w3} nf=1 ad='int((nf+1)/2) * W/nf * 0.18u' as='int((nf+2)/2) * W/nf * 0.18u' pd='2*int((nf+1)/2) * (W/nf + 0.18u)'
+ ps='2*int((nf+2)/2) * (W/nf + 0.18u)' nrd='0.18u / W' nrs='0.18u / W' sa=0 sb=0 sd=0
XM9 P CK VDD VDD pfet_03v3 L=0.28u W={w3} nf=1 ad='int((nf+1)/2) * W/nf * 0.18u' as='int((nf+2)/2) * W/nf * 0.18u' pd='2*int((nf+1)/2) * (W/nf + 0.18u)'
+ ps='2*int((nf+2)/2) * (W/nf + 0.18u)' nrd='0.18u / W' nrs='0.18u / W' sa=0 sb=0 sd=0
XM10 Y CK VDD VDD pfet_03v3 L=0.28u W={w3} nf=1 ad='int((nf+1)/2) * W/nf * 0.18u' as='int((nf+2)/2) * W/nf * 0.18u' pd='2*int((nf+1)/2) * (W/nf + 0.18u)'
+ ps='2*int((nf+2)/2) * (W/nf + 0.18u)' nrd='0.18u / W' nrs='0.18u / W' sa=0 sb=0 sd=0
XM11 Q CK VDD VDD pfet_03v3 L=0.28u W={w3} nf=1 ad='int((nf+1)/2) * W/nf * 0.18u' as='int((nf+2)/2) * W/nf * 0.18u' pd='2*int((nf+1)/2) * (W/nf + 0.18u)'
+ ps='2*int((nf+2)/2) * (W/nf + 0.18u)' nrd='0.18u / W' nrs='0.18u / W' sa=0 sb=0 sd=0
V1 CK 0 PULSE(0 {vdd} {tper/2} {tr} {tr} {tper/2-tr} {tper})
Vcm Vcm 0 dc {vcm}
Vip vip Vcm dc 0
Vim vim Vcm dc 0
XM14 net2 Y 0 0 nfet_03v3 L=0.28u W={w4} nf=1 ad='int((nf+1)/2) * W/nf * 0.18u' as='int((nf+2)/2) * W/nf * 0.18u' pd='2*int((nf+1)/2) * (W/nf + 0.18u)'
+ ps='2*int((nf+2)/2) * (W/nf + 0.18u)' nrd='0.18u / W' nrs='0.18u / W' sa=0 sb=0 sd=0
XM15 net2 Y VDD VDD pfet_03v3 L=0.28u W={w4*k2} nf=1 ad='int((nf+1)/2) * W/nf * 0.18u' as='int((nf+2)/2) * W/nf * 0.18u' pd='2*int((nf+1)/2) * (W/nf + 0.18u)'
+ ps='2*int((nf+2)/2) * (W/nf + 0.18u)' nrd='0.18u / W' nrs='0.18u / W' sa=0 sb=0 sd=0
XM12 net3 X VDD VDD pfet_03v3 L=0.28u W={w4*k2} nf=1 ad='int((nf+1)/2) * W/nf * 0.18u' as='int((nf+2)/2) * W/nf * 0.18u' pd='2*int((nf+1)/2) * (W/nf + 0.18u)'
+ ps='2*int((nf+2)/2) * (W/nf + 0.18u)' nrd='0.18u / W' nrs='0.18u / W' sa=0 sb=0 sd=0
XM13 net3 X 0 0 nfet_03v3 L=0.28u W={w4} nf=1 ad='int((nf+1)/2) * W/nf * 0.18u' as='int((nf+2)/2) * W/nf * 0.18u' pd='2*int((nf+1)/2) * (W/nf + 0.18u)'
+ ps='2*int((nf+2)/2) * (W/nf + 0.18u)' nrd='0.18u / W' nrs='0.18u / W' sa=0 sb=0 sd=0
**** begin user architecture code

.include /home/vicente/open_pdks/gf180mcu/gf180mcuD/libs.tech/ngspice/design.ngspice
.lib /home/vicente/open_pdks/gf180mcu/gf180mcuD/libs.tech/ngspice/sm141064.ngspice typical
.include /home/vicente/iclab/comparator/mm_models.spice

* transistor widths
.param w1=5u 	k1=1
.param w2=5u k2=2
.param w3=0.22u
.param w4=5u

.param vdd=3.3
.param vcm={vdd/2}
.param fclk=100e6
.param tper={1/fclk}
.param tr=100p
.param tdly={tper/2}
.param ncyc_ramp=150
.param vr=60m
.param tstop={ncyc_ramp*tper}

.csparam tper={tper}
.csparam tdly={tdly}
.csparam tstop={tstop}
.csparam vr={vr}
.csparam vdd={vdd}
.csparam ncyc_ramp={ncyc_ramp}

.param sw_stat_mismatch=1
.options reltol=1e-6 abstol=1e-14 vntol=1e-9

.control
set nruns = 200
set vrg = 0.06
set nbis = 10
set tev = 9.8e-9

foreach vc 800 900 1200 1300 1500 1650 1800
  shell rm -f vos_bis_vcm_$vc
  let vcv = $vc/1000

  repeat $nruns
    reset
    alter Vcm dc = $&vcv
    set lo = -$vrg
    set hi = $vrg

    repeat $nbis
      let midv = (($lo) + ($hi))/2
      set mid = $&midv
      let hp = ($mid)/2
      let hn = -($mid)/2
      alter Vip dc = $&hp
      alter Vim dc = $&hn

      tran 10p $tev

      let dfin = v(y)[length(v(y))-1] - v(x)[length(v(x))-1]
      if $&dfin > 0
        set hi = $mid
      else
        set lo = $mid
      end
      destroy all
    end

    let trip = (($lo) + ($hi))/2
    let oor = abs(trip)/$vrg
    echo $&trip $&oor >> vos_bis_vcm_$vc
    destroy all
  end
end
.endc

**** end user architecture code
**.ends
.GLOBAL VDD
.end
