** sch_path: /home/vicente/iclab/comparator/comparator.sch
**.subckt comparator
VDD VDD 0 dc {vdd}
XM1 net1 CK net7 0 nfet_03v3 L={lck} W={wck} nf={nfck} ad='int((nf+1)/2) * W/nf * 0.18u' as='int((nf+2)/2) * W/nf * 0.18u' pd='2*int((nf+1)/2) * (W/nf + 0.18u)'
+ ps='2*int((nf+2)/2) * (W/nf + 0.18u)' nrd='0.18u / W' nrs='0.18u / W' sa=0 sb=0 sd=0
XM2 P vip net1 0 nfet_03v3 L=0.28u W={w1} nf={nf1} ad='int((nf+1)/2) * W/nf * 0.18u' as='int((nf+2)/2) * W/nf * 0.18u' pd='2*int((nf+1)/2) * (W/nf + 0.18u)'
+ ps='2*int((nf+2)/2) * (W/nf + 0.18u)' nrd='0.18u / W' nrs='0.18u / W' sa=0 sb=0 sd=0
Xq X Y P 0 nfet_03v3 L=0.28u W={w2} nf={nf2} ad='int((nf+1)/2) * W/nf * 0.18u' as='int((nf+2)/2) * W/nf * 0.18u' pd='2*int((nf+1)/2) * (W/nf + 0.18u)'
+ ps='2*int((nf+2)/2) * (W/nf + 0.18u)' nrd='0.18u / W' nrs='0.18u / W' sa=0 sb=0 sd=0
XM4 X Y VDD VDD pfet_03v3 L=0.28u W={w5} nf={nf5} ad='int((nf+1)/2) * W/nf * 0.18u' as='int((nf+2)/2) * W/nf * 0.18u' pd='2*int((nf+1)/2) * (W/nf + 0.18u)'
+ ps='2*int((nf+2)/2) * (W/nf + 0.18u)' nrd='0.18u / W' nrs='0.18u / W' sa=0 sb=0 sd=0
XM5 Q vim net1 0 nfet_03v3 L=0.28u W={w1} nf={nf1} ad='int((nf+1)/2) * W/nf * 0.18u' as='int((nf+2)/2) * W/nf * 0.18u' pd='2*int((nf+1)/2) * (W/nf + 0.18u)'
+ ps='2*int((nf+2)/2) * (W/nf + 0.18u)' nrd='0.18u / W' nrs='0.18u / W' sa=0 sb=0 sd=0
XM6 Y X Q 0 nfet_03v3 L=0.28u W={w2} nf={nf2} ad='int((nf+1)/2) * W/nf * 0.18u' as='int((nf+2)/2) * W/nf * 0.18u' pd='2*int((nf+1)/2) * (W/nf + 0.18u)'
+ ps='2*int((nf+2)/2) * (W/nf + 0.18u)' nrd='0.18u / W' nrs='0.18u / W' sa=0 sb=0 sd=0
XM7 Y X VDD VDD pfet_03v3 L=0.28u W={w5} nf={nf5} ad='int((nf+1)/2) * W/nf * 0.18u' as='int((nf+2)/2) * W/nf * 0.18u' pd='2*int((nf+1)/2) * (W/nf + 0.18u)'
+ ps='2*int((nf+2)/2) * (W/nf + 0.18u)' nrd='0.18u / W' nrs='0.18u / W' sa=0 sb=0 sd=0
XM8 X CK VDD VDD pfet_03v3 L=0.28u W={w3} nf={nf3} ad='int((nf+1)/2) * W/nf * 0.18u' as='int((nf+2)/2) * W/nf * 0.18u' pd='2*int((nf+1)/2) * (W/nf + 0.18u)'
+ ps='2*int((nf+2)/2) * (W/nf + 0.18u)' nrd='0.18u / W' nrs='0.18u / W' sa=0 sb=0 sd=0
XM9 P CK VDD VDD pfet_03v3 L=0.28u W={w3} nf={nf3} ad='int((nf+1)/2) * W/nf * 0.18u' as='int((nf+2)/2) * W/nf * 0.18u' pd='2*int((nf+1)/2) * (W/nf + 0.18u)'
+ ps='2*int((nf+2)/2) * (W/nf + 0.18u)' nrd='0.18u / W' nrs='0.18u / W' sa=0 sb=0 sd=0
XM10 Y CK VDD VDD pfet_03v3 L=0.28u W={w3} nf={nf3} ad='int((nf+1)/2) * W/nf * 0.18u' as='int((nf+2)/2) * W/nf * 0.18u' pd='2*int((nf+1)/2) * (W/nf + 0.18u)'
+ ps='2*int((nf+2)/2) * (W/nf + 0.18u)' nrd='0.18u / W' nrs='0.18u / W' sa=0 sb=0 sd=0
XM11 Q CK VDD VDD pfet_03v3 L=0.28u W={w3} nf={nf3} ad='int((nf+1)/2) * W/nf * 0.18u' as='int((nf+2)/2) * W/nf * 0.18u' pd='2*int((nf+1)/2) * (W/nf + 0.18u)'
+ ps='2*int((nf+2)/2) * (W/nf + 0.18u)' nrd='0.18u / W' nrs='0.18u / W' sa=0 sb=0 sd=0
V1 ck_raw 0 PULSE({v0_ck} {vdd} {tdly} {tr} {tr} {tper/2-tr} {tper})
Vcm Vcm 0 dc {vcm}
Vip vip Vcm dc 0
Vim vim Vcm dc 0
XM14 net2 Y 0 0 nfet_03v3 L=0.28u W={w4} nf={nf4} ad='int((nf+1)/2) * W/nf * 0.18u' as='int((nf+2)/2) * W/nf * 0.18u' pd='2*int((nf+1)/2) * (W/nf + 0.18u)'
+ ps='2*int((nf+2)/2) * (W/nf + 0.18u)' nrd='0.18u / W' nrs='0.18u / W' sa=0 sb=0 sd=0
XM15 net2 Y VDD VDD pfet_03v3 L=0.28u W={w4*k2} nf={nf4} ad='int((nf+1)/2) * W/nf * 0.18u' as='int((nf+2)/2) * W/nf * 0.18u' pd='2*int((nf+1)/2) * (W/nf + 0.18u)'
+ ps='2*int((nf+2)/2) * (W/nf + 0.18u)' nrd='0.18u / W' nrs='0.18u / W' sa=0 sb=0 sd=0
XM12 net3 X VDD VDD pfet_03v3 L=0.28u W={w4*k2} nf={nf4} ad='int((nf+1)/2) * W/nf * 0.18u' as='int((nf+2)/2) * W/nf * 0.18u' pd='2*int((nf+1)/2) * (W/nf + 0.18u)'
+ ps='2*int((nf+2)/2) * (W/nf + 0.18u)' nrd='0.18u / W' nrs='0.18u / W' sa=0 sb=0 sd=0
XM13 net3 X 0 0 nfet_03v3 L=0.28u W={w4} nf={nf4} ad='int((nf+1)/2) * W/nf * 0.18u' as='int((nf+2)/2) * W/nf * 0.18u' pd='2*int((nf+1)/2) * (W/nf + 0.18u)'
+ ps='2*int((nf+2)/2) * (W/nf + 0.18u)' nrd='0.18u / W' nrs='0.18u / W' sa=0 sb=0 sd=0
XM17 net4 VDD net5 0 nfet_03v3 L={lck} W={wck*k} nf=1 ad='int((nf+1)/2) * W/nf * 0.18u' as='int((nf+2)/2) * W/nf * 0.18u' pd='2*int((nf+1)/2) * (W/nf + 0.18u)'
+ ps='2*int((nf+2)/2) * (W/nf + 0.18u)' nrd='0.18u / W' nrs='0.18u / W' sa=0 sb=0 sd=0
XM18 net5 vtail 0 0 nfet_03v3 L={ltail} W={wtail*k} nf=1 ad='int((nf+1)/2) * W/nf * 0.18u' as='int((nf+2)/2) * W/nf * 0.18u' pd='2*int((nf+1)/2) * (W/nf + 0.18u)'
+ ps='2*int((nf+2)/2) * (W/nf + 0.18u)' nrd='0.18u / W' nrs='0.18u / W' sa=0 sb=0 sd=0
XM19 vtail vim net4 0 nfet_03v3 L=0.28u W={w1*k} nf=1 ad='int((nf+1)/2) * W/nf * 0.18u' as='int((nf+2)/2) * W/nf * 0.18u' pd='2*int((nf+1)/2) * (W/nf + 0.18u)'
+ ps='2*int((nf+2)/2) * (W/nf + 0.18u)' nrd='0.18u / W' nrs='0.18u / W' sa=0 sb=0 sd=0
I0 VDD vtail {Imirr*k}
XM3 CK net6 0 0 nfet_03v3 L=0.28u W={w7} nf={nf7} ad='int((nf+1)/2) * W/nf * 0.18u' as='int((nf+2)/2) * W/nf * 0.18u' pd='2*int((nf+1)/2) * (W/nf + 0.18u)'
+ ps='2*int((nf+2)/2) * (W/nf + 0.18u)' nrd='0.18u / W' nrs='0.18u / W' sa=0 sb=0 sd=0
XM16 CK net6 VDD VDD pfet_03v3 L=0.28u W={w7*k7} nf={nf7} ad='int((nf+1)/2) * W/nf * 0.18u' as='int((nf+2)/2) * W/nf * 0.18u' pd='2*int((nf+1)/2) * (W/nf + 0.18u)'
+ ps='2*int((nf+2)/2) * (W/nf + 0.18u)' nrd='0.18u / W' nrs='0.18u / W' sa=0 sb=0 sd=0
XM20 net6 ck_raw VDD VDD pfet_03v3 L=0.28u W={w6*k6} nf={nf6} ad='int((nf+1)/2) * W/nf * 0.18u' as='int((nf+2)/2) * W/nf * 0.18u' pd='2*int((nf+1)/2) * (W/nf + 0.18u)'
+ ps='2*int((nf+2)/2) * (W/nf + 0.18u)' nrd='0.18u / W' nrs='0.18u / W' sa=0 sb=0 sd=0
XM21 net6 ck_raw 0 0 nfet_03v3 L=0.28u W={w6} nf={nf6} ad='int((nf+1)/2) * W/nf * 0.18u' as='int((nf+2)/2) * W/nf * 0.18u' pd='2*int((nf+1)/2) * (W/nf + 0.18u)'
+ ps='2*int((nf+2)/2) * (W/nf + 0.18u)' nrd='0.18u / W' nrs='0.18u / W' sa=0 sb=0 sd=0
XM22 net7 vtail 0 0 nfet_03v3 L={ltail} W={wtail} nf=1 ad='int((nf+1)/2) * W/nf * 0.18u' as='int((nf+2)/2) * W/nf * 0.18u' pd='2*int((nf+1)/2) * (W/nf + 0.18u)'
+ ps='2*int((nf+2)/2) * (W/nf + 0.18u)' nrd='0.18u / W' nrs='0.18u / W' sa=0 sb=0 sd=0
XM23 vtail vip net4 0 nfet_03v3 L=0.28u W={w1*k} nf=1 ad='int((nf+1)/2) * W/nf * 0.18u' as='int((nf+2)/2) * W/nf * 0.18u' pd='2*int((nf+1)/2) * (W/nf + 0.18u)'
+ ps='2*int((nf+2)/2) * (W/nf + 0.18u)' nrd='0.18u / W' nrs='0.18u / W' sa=0 sb=0 sd=0
**** begin user architecture code

.include /home/vicente/open_pdks/gf180mcu/gf180mcuD/libs.tech/ngspice/design.ngspice
.lib /home/vicente/open_pdks/gf180mcu/gf180mcuD/libs.tech/ngspice/sm141064.ngspice typical
.include /home/vicente/iclab/comparator/mm_models.spice

* transistor widths
.param nf1=1 w1=5u		k1=2 		; input pair and tail
.param lck=0.28u nfck=1 wck={w1*k1}
.param nf2=1 w2={0.22u*nf2}		k2=2		; xc inv nmos
.param nf5=1 w5={0.22u*nf5}			; xc inv pmos
.param nf3=2 w3={0.22u*nf3}				; switches
.param nf4=1 w4={0.22u*4}		        ; out inv
.param nf6=1 w6={0.22u*4} k6=2
.param nf7=1 w7={0.22u*8} k7=2
.param ltail=0.28u wtail=5u
.param Imirr=350u
.param k=1

.param vcm_b=1.65
.param vdd=3.3
.param v0_ck=0
.param vcm={vdd/2}
.param fclk=50e6
.param tper={1/fclk}
.param tr=100p
.param tdly=1n
.param ncyc_ramp=150
.param vr=60m
.param tstop={ncyc_ramp*tper}

.csparam fclk={fclk}
.csparam w1={w1}
.csparam k1={w1}
.csparam w2={w5}
.csparam k2={k2}
.csparam w5={w5}

.param sw_stat_mismatch=1
.options reltol=1e-6 abstol=1e-14 vntol=1e-9

.control
*source /home/vicente/iclab/comparator/scripts/controls/sweep_vcm.cir
*source /home/vicente/iclab/comparator/scripts/controls/sweep_vcm_wpair.cir
*source /home/vicente/iclab/comparator/scripts/controls/sweep_vcm_xcwn.cir
*source /home/vicente/iclab/comparator/scripts/controls/sweep_vcm_xcwn_diff.cir
;source /home/vicente/iclab/comparator/scripts/comparator/controls/sweep_xcwp.cir
*source /home/vicente/iclab/comparator/scripts/controls/sweep_vcm.cir
;source /home/vicente/iclab/comparator/scripts/comparator/controls/sweep_vcm.cir
source /home/vicente/iclab/comparator/scripts/comparator/controls/sweep_vcm_wpair.cir
;source /home/vicente/iclab/comparator/scripts/comparator/controls/imax.cir
;tran 10p 4e-9
.endc

**** end user architecture code
**.ends
.GLOBAL VDD
.end
